* Diode DC sweep with .step (Xyce): three steps of one sweep.
V1 in 0 DC 0
R1 in a 1k
D1 a 0 dmod
.model dmod D(IS=1e-14)
.dc V1 0 2 0.1
.step R1 1k 4k 1.5k
.end
