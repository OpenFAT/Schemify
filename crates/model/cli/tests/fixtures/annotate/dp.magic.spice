* NGSPICE file created from dp.ext - technology: sky130A

.subckt dp outn outp inp inn tail VSS
X0 tail inp a_n140_n60# VSS sky130_fd_pr__nfet_01v8 ad=0.58 pd=4.58 as=0.58 ps=4.58 w=2 l=0.15
X1 outn inn tail VSS sky130_fd_pr__nfet_01v8 ad=0.58 pd=4.58 as=0.58 ps=4.58 w=2 l=0.15
R0 a_n140_n60# outp 18.2
C0 outp outn 0.21f
C1 inp a_n140_n60# 0.35f
C2 inn outn 0.35f
C3 outp VSS 1.24f $ **FLOATING
C4 outn VSS 1.19f $ **FLOATING
C5 tail VSS 2.07f $ **FLOATING
.ends
