* inv (schemify ngspice)
XM1 Y A VDD VDD sky130_fd_pr__pfet_01v8 L=0.5 W=2 nf=2 mult=1 m=1
XM2 Y A VSS VSS sky130_fd_pr__nfet_01v8 L=0.5 W=1 nf=1 mult=1 m=1
.end
